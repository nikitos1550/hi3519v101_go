/*
0x1204____
0x1204_0000 0x1204_07FF I/O MUX configuration register 2 KB Multiplexing relationship
0x1204_0800 0x1204_FFFF I/O CTRL configuration register 62 KB Drive current

0x1203____
0x1206____

0x1201____
0x1201_0000 0x1201_FFFF CRG register 64 KB


0x120a____
0x113c____
0x114c____
0x1104____
0x1214____
*/

regfile eMUX {

  
reg {
    desc = "FLASH_TRIG pin multiplexing control register.";

    /*enum link_status_enum {
        gpio1_0 = 2'b00  { desc = "No link peer is currently detected"; };
        flash_trig    = 2'b01  { desc = "Link is currently training"; };
        spi2_csn1      = 2'b10  { desc = "Link is in a partial low power state"; };
        pwm4       = 2'b11  { desc = "Link is a Full low power state"; };
    };*/

    field {
        desc = "FLASH_TRIG pin Function sel";
        //encode = link_status_enum;
    } value[0:1];

} muxctrl_reg0 @ 0x0000;


/*
reg { 
    desc = "SHUTTER_TRIG pin multiplexing control register."
} muxctrl_reg1 @ 0x0004;

reg {
    desc = "SENSOR1_CLK pin multiplexing control register.";  
} muxctrl_reg2 @ 0x0008;

reg {
    desc = "SENSOR1_RSTN pin multiplexing control register.";
} muxctrl_reg3 @ 0x000C;

reg {
    desc = "SENSOR1_HS pin multiplexing control register.";
} muxctrl_reg4 @ 0x0010;

reg {
    desc ="SENSOR1_VS pin multiplexing control register.";
} muxctrl_reg5 @ 0x0014

reg {
    desc = "SPI1_SCLK pin multiplexing control register.";
} muxctrl_reg6 @ 0x0018;

reg {
    desc = "SPI1_SDO pin multiplexing control register.";
} muxctrl_reg7 @ 0x001C;

reg {
    desc = "SPI1_SDI pin multiplexing control register.";
} muxctrl_reg8 @ 0x0020;

reg {
    desc = "SPI1_CSN pin multiplexing control register.";
} muxctrl_reg9 @ 0x0024;

reg {
    desc = "VI1_HS pin multiplexing control register.";
} muxctrl_reg10 @

reg {
    desc = "VI1_VS pin multiplexing control register.";
} muxctrl_reg11 @
reg {
    desc = "VI1_CLK pin multiplexing control register.";
} muxctrl_reg12 @
reg {
    desc = "VI1_DATA0 pin multiplexing control register.";
} muxctrl_reg13 @
reg {
    desc = "VI1_DATA1 pin multiplexing control register.";
} muxctrl_reg14 @
reg {
    desc = "VI1_DATA2 pin multiplexing control register.";
} muxctrl_reg15 @
reg {
    desc = "VI1_DATA3 pin multiplexing control register.";
} muxctrl_reg16 @
reg {
    desc = "VI1_DATA4 pin multiplexing control register.";
} muxctrl_reg17 @
reg {
    desc = "VI1_DATA5 pin multiplexing control register.";
} muxctrl_reg18 @
reg {
    desc = "SPI2_SCLK pin multiplexing control register.";
} muxctrl_reg19 @
reg {
    desc = "SPI2_SDO pin multiplexing control register.";
} muxctrl_reg20 @
reg {
    desc = "SPI2_SDI pin multiplexing control register.";
} muxctrl_reg21 @
reg {
    desc = "SPI2_CSN0 pin multiplexing control register.";
} muxctrl_reg22 @
reg {
    desc = "I2C2_SDA pin multiplexing control register.";
} muxctrl_reg23 @
reg {
    desc = "I2C2_SCL pin multiplexing control register.";
} muxctrl_reg24 @
reg {
    desc = "JTAG_TRSTN pin multiplexing control register.";
} muxctrl_reg25 @
reg {
    desc = "JTAG_TCK pin multiplexing control register.";
} muxctrl_reg26
reg {
    desc = "JTAG_TMS pin multiplexing control register.";
} muxctrl_reg27
reg {
    desc = "JTAG_TDO pin multiplexing control register.";
} muxctrl_reg28
reg {
    desc = "JTAG_TDI pin multiplexing control register.";
} muxctrl_reg29
reg {
    desc = "PWM0 pin multiplexing control register.";
} muxctrl_reg30
reg {
    desc = "PWM1 pin multiplexing control register.";
} muxctrl_reg31
reg {
    desc = "PWM2 pin multiplexing control register."; 
} muxctrl_reg32
reg {
    desc = "PWM3 pin multiplexing control register.";
} muxctrl_reg33
reg {
    desc = "UART1_RTSN pin multiplexing control register.";
} muxctrl_reg34
reg {
    desc = "UART1_RXD pin multiplexing control register.";
} muxctrl_reg35
reg {
    desc = "UART1_CTSN pin multiplexing control register.";
} muxctrl_reg36
reg {
    desc = "UART1_TXD pin multiplexing control register.";
} muxctrl_reg37
reg {
    desc = "UART2_RXD pin multiplexing control register.";
} muxctrl_reg38
reg {
    desc = "UART2_TXD pin multiplexing control register.";
} muxctrl_reg39
reg {
    desc = "UART2_RTSN pin multiplexing control register.";
} muxctrl_reg40
reg {
    desc = "UART2_CTSN pin multiplexing control register.";
} muxctrl_reg41
reg {
    desc = "USB3_PWREN pin multiplexing control register.";
} muxctrl_reg42
reg {
    desc = "SDIO0_CARD_POWER_EN pin multiplexing control register.";
} muxctrl_reg43
reg {
    desc = "SDIO0_CARD_DETECT pin multiplexing control register.";
} muxctrl_reg44
reg {
    desc = "SDIO0_CWPR pin multiplexing control register.";
} muxctrl_reg45
reg {
    desc = "SDIO0_CCLK_OUT pin multiplexing control register.";
} muxctrl_reg46
reg {
    desc = "SDIO0_CCMD pin multiplexing control register.";
} muxctrl_reg47
reg {
    desc = "SDIO0_CDATA0 pin multiplexing control register.";
} muxctrl_reg48
reg {
    desc = "SDIO0_CDATA1 pin multiplexing control register.";
} muxctrl_reg49
reg {
    desc = "SDIO0_CDATA2 pin multiplexing control register.";
} muxctrl_reg50
reg {
    desc = "SDIO0_CDATA3 pin multiplexing control register.";
} muxctrl_reg51
reg {
    desc = "SDIO1_CARD_POWER_EN pin multiplexing control register.";
} muxctrl_reg52
reg {
    desc = "SDIO1_CARD_DETECT pin multiplexing control register.";
} muxctrl_reg53
reg {
    desc = "SDIO1_CWPR pin multiplexing control register.";
} muxctrl_reg54 @
reg {
    desc = "SDIO1_CCLK_OUT pin multiplexing control register.";
} muxctrl_reg55
reg {
    desc = "SDIO1_CCMD pin multiplexing control register.";
} muxctrl_reg56 @
reg {
    desc = "SDIO1_CDATA0 pin multiplexing control register.";
} muxctrl_reg57 @
reg {
    desc = "SDIO1_CDATA1 pin multiplexing control register.";
} muxctrl_reg58 @
reg {
    desc ="SDIO1_CDATA2 pin multiplexing control register.";
} muxctrl_reg59 @
reg {
    desc = "SDIO1_CDATA3 pin multiplexing control register.";
} muxctrl_reg60 @
reg {
    desc = "USB2_PWREN pin multiplexing control register.";
} muxctrl_reg61 @
reg {
    desc = "VO_CLK pin multiplexing control register.";
} muxctrl_reg62 @
reg {
    desc = "VO_DATA0 pin multiplexing control register.";
} muxctrl_reg63 @
reg {
    desc = "VO_DATA1 pin multiplexing control register.";
} muxctrl_reg64 @
reg {
    desc = "VO_DATA2 pin multiplexing control register.";
} muxctrl_reg65 @
reg {
    desc ="VO_DATA3 pin multiplexing control register.";
} muxctrl_reg66 @
reg {
    desc = "VO_DATA4 pin multiplexing control register.";
} muxctrl_reg67 @
reg {
    desc ="VO_DATA5 pin multiplexing control register.";
] muxctrl_reg68 @
reg {
    desc = "VO_DATA6 pin multiplexing control register.";
} muxctrl_reg69 @
reg {
    desc = "VO_DATA7 pin multiplexing control register.";
} muxctrl_reg70 @
reg {
    desc ="VO_DATA8 pin multiplexing control register.";
} muxctrl_reg71 @
reg {
    desc ="VO_DATA9 pin multiplexing control register.";
} muxctrl_reg72 @
reg {
    desc ="VO_DATA10 pin multiplexing control register.";
} muxctrl_reg73 @
reg {
    desc ="VO_DATA11 pin multiplexing control register.";
} muxctrl_reg74
reg {
    desc = "VO_DATA12 pin multiplexing control register.";
} muxctrl_reg75 @
reg {
    desc = "VO_DATA13 pin multiplexing control register.";
} muxctrl_reg76 @
reg {
    desc ="VO_DATA14 pin multiplexing control register.";
} muxctrl_reg77 @
reg {
    desc = "VO_DATA15 pin multiplexing control register.";
} muxctrl_reg78 @

reg {
    desc = "RGMII_TX_EN pin multiplexing control register.";
} muxctrl_reg79 @
reg {
    desc ="RGMII_TX_CLK pin multiplexing control register.";
} muxctrl_reg80 @
reg {
    desc = "RGMII_TXD0 pin multiplexing control register.";
} muxctrl_reg81 @
reg {
    desc = "RGMII_TXD1 pin multiplexing control register.";
} muxctrl_reg82 @
reg {
    desc = "RGMII_TXD2 pin multiplexing control register.";
} muxctrl_reg83 @
reg {
    desc = "RGMII_TXD3 pin multiplexing control register.";
} muxctrl_reg84 @
reg {
    desc = "RGMII_RX_CLK pin multiplexing control register."
} muxctrl_reg85 @
reg {
    desc = "RGMII_RX_DV pin multiplexing control register.";
} muxctrl_reg86 @ 
reg {
    desc ="RGMII_RXD0 pin multiplexing control register.";
} muxctrl_reg87 @
reg {
    desc = "RGMII_RXD1 pin multiplexing control register.";
} muxctrl_reg88 @

reg {
    desc = "RGMII_RXD2 pin multiplexing control register.";
} muxctrl_reg89 @
reg {
    desc = "RGMII_RXD3 pin multiplexing control register.";
} muxctrl_reg90 @ 0x
reg {
    desc = "EPHY_RSTN pin multiplexing control register.";
} muxctrl_reg91 @ 0x

reg {
    desc = "EPHY_CLK pin multiplexing control register.";
} muxctrl_reg92 @ 0x

reg { 
    desc = "MDCK pin multiplexing control register.";
} muxctrl_reg93 @ 0x
reg {
    desc = "MDIO pin multiplexing control register.";
} muxctrl_reg94 @ 0x
reg {
    desc = "SENSOR0_CLK pin multiplexing control register.";
}  muxctrl_reg95 @ 0x
reg {
    desc = "SENSOR0_RSTN pin multiplexing control register."; 
} muxctrl_reg96 @ 0x0180;
reg {
    dec = "SENSOR0_HS pin multiplexing control register.";
} muxctrl_reg97 @ 0x0184;
reg {
    desc = "SENSOR0_VS pin multiplexing control register.";
} muxctrl_reg98 @ 0x0188;
reg {
    desc = "SPI0_SCLK pin multiplexing control register.";
} muxctrl_reg99 @ 0x018C;
reg {
    desc = "SPI0_SDO pin multiplexing control register."; 
} muxctrl_reg100 @ 0x0190;
reg {
    desc = "SPI0_SDI pin multiplexing control register.";
} muxctrl_reg101 @ 0x0194;

reg {
    desc = "SPI0_CSN pin multiplexing control register.";
} muxctrl_reg102 @ 0x0198;

reg {
    desc ="SAR_ADC_CH1 pin multiplexing control register.";  
} muxctrl_reg118 @ 0x01D8;

reg {
    desc = "SAR_ADC_CH2 pin multiplexing control register.";
} muxctrl_reg119 @ 0x01DC;

reg { 
    desc = "SAR_ADC_CH3 pin multiplexing control register."
} muxctrl_reg120 @ 0x01E0;
*/

};

regfile eCRG {
    name = "CRG...";
/*
    reg {
        desc = "APLL configuration register 0";

        field {
            desc = "Reserved";
        } reserved2[31:31] = 0;
        field {
            desc = "Level-2 output frequency divider of the APLL";
        } apll_postdiv2[30:28];
        field {
            desc = "Reserved";
        } reserved1[27:27];
        field {
            desc = "Level-1 output frequency divider of the APLL";
        } apll_postdiv1[26:24];
        field {
            desc = "Decimal part of the APLL frequency multiplication coefficient";
        } apll_frac[23:0];

    } PERI_CRG_PLL0 @ 0x0000;
*/
/*
    reg {
        desc = "APLL configuration register 1";
    } PERI_CRG_PLL1 @ 0x0004;

    reg {
        desc = "DPLL configuration register 0";
    } PERI_CRG_PLL4 @ 0x0010;

    reg {
        desc = "DPLL configuration register 1";
    } PERI_CRG_PLL5 @ 0x0014;

    reg {
        desc = "VPLL configuration register 0";
    } PERI_CRG_PLL6 @ 0x0018;

    reg {
        desc = "VPLL configuration register 1";
    } PERI_CRG_PLL7 @ 0x001C;

    reg {
        desc = "EPLL configuration register 0";
    } PERI_CRG_PLL8 @ 0x0020;

    reg {
        desc = "EPLL configuration register 1";
    } PERI_CRG_PLL9 @ 0x0024;

    reg {
        desc = "CoreSight & A17 clock reset configuration register";
    } PERI_CRG10 @ 0x0028;

    reg {
        desc = "A7 clock reset configuration register";
    } PERI_CRG11 @ 0x002C;

    reg {
        desc = "DDR clock configuration register";
    } PERI_CRG12 @ 0x0030;

    reg {
        desc = "SoC frequency configuration register"
    } PERI_CRG13 @ 0x0034;

    reg {
        desc = "VI-MIPI clock reset configuration register";
    } PERI_CRG15 @ 0x003C;

    reg {
        desc = "Sensor clock configuration register";
    } PERI_CRG16 @ 0x0040;

    reg {
        desc = "VDP clock and reset control register"
    } PERI_CRG17 @ 0x0044;

    reg {
        desc = "LCD clock configuration register";
    } PERI_CRG18 @ 0x0048;

    reg {
        desc = "Media CBB frequency profile configuration register 1";
    } PERI_CRG19 @ 0x004C;

    reg {
        desc = "VEDU clock and soft reset control register";
    } PERI_CRG20 @ 0x0050;

    reg {
        desc = "Media CBB frequency configuration register 2";
    } PERI_CRG21 @ 0x0054;

    reg {
        desc = "VPSS clock and soft reset control register";
    } PERI_CRG22 @ 0x0058;

    reg {
        desc = "VGS clock and soft reset control register";
    } PERI_CRG23 @ 0x005C;

    reg {
        desc = "JPGE clock and soft reset control register";
    } PERI_CRG24 @ 0x0060;

    reg {
        desc = "TDE clock and soft reset control register";
    } PERI_CRG25 @ 0x0064;

    reg {
        desc = "IVE clock and soft reset control register";
    } PERI_CRG27 @ 0x006C;

    reg {
        desc = "GDC clock and soft reset control register";
    } PERI_CRG29 @ 0x0074;

    reg {
        desc = "Hash/LSADC/Cipher clock and soft reset control register";
    } PERI_CRG31 @ 0x007C;
     
    reg {
        desc = "AIAO clock reset control register";
    } PERI_CRG32 @ 0x0080;

    reg {
        desc = "GZIP clock and soft reset control register";
    } PERI_CRG33 @ 0x0084;

    reg {
        desc = "COMB PHY clock reset control register";
    } PERI_CRG43 @ 0x00AC;
    reg {
        desc = "PCIe CTRL clock and soft reset control register";
    } PERI_CRG44 @ 0x00B0;
    reg {
        desc = "USB 2.0 clock and soft reset control register";
    } PERI_CRG45 @ 0x00B4;
    reg {
        desc = "USB 3.0 CTRL clock and soft reset control register";
    } PERI_CRG46 @ 0x00B8;
    reg {
        desc = "FMC clock and soft reset control register";
    } PERI_CRG48 @ 0x00C0;
    reg {
        desc = "MMC0/1/2 clock and soft reset control register";
    } PERI_CRG49 @ 0x00C4;
    reg {
        desc = "GSF/GMAC clock and soft reset control register";
    } PERI_CRG51 @ 0x00CC;
    reg {
        desc = "DDRT and IO_HPM clock and soft reset control register";
    } PERI_CRG54 @ 0x00D8;
    reg {
        desc = "PWM clock and reset control register";
    } PERI_CRG55 @ 0x00DC;
    reg {
        desc = "RSA/TRNG/KLAD/DMA clock and soft reset control register";
    } PERI_CRG56 @ 0x00E0;
    reg {
        desc = "Clock soft reset control register for other APB modules";
    } PERI_CRG57 @ 0x00E4;
    reg {
        desc = "CRG status register";
    } PERI_CRG58 @ 0x00E8;
    reg {
        desc = "GMAC interface control register";
    } PERI_CRG59 @ 0x00EC:
    reg {
        desc = "GMAC interface status register";
    } PERI_CRG60 @ 0x00F0
    reg {
        desc = "SoC frequency status register";
    } PERI_CRG79 @ 0x013C;
*/
};

addrmap hi3516av200 {
    //eCRG CRG @ 0x12010000;
    eMUX MUX @ 0x12040000;
};
